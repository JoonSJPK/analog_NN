.title analog_NN analog
.include "/Users/joon/Projects/Wim/analog_NN/dig_ana_sim_out/models/AD5160.lib"
.include "/Users/joon/Projects/Wim/analog_NN/TLV9061_generic.lib"
C78 Net-_U42-EN_ 0 10u
R48 Net-_J1-CC1_ 0 5.1k
R49 Net-_J1-CC2_ 0 5.1k
C80 Net-_U42-EN_ 0 1u
C81 0 VREF 10u
R51 Net-_C75-Pad1_ Net-_U40-XOUT_ 1k
C75 Net-_C75-Pad1_ 0 15p
XU2 VREF 0 Net-_U2-+_ VREF VCC TLV9061
C70 0 VCC 100n
C76 Net-_U40-XIN_ 0 15p
R53 Net-_U2-+_ 0 10k
C77 Net-_U42-BP_ 0 470p
C79 VCC 0 10u
C82 0 Net-_U2-+_ 100n
R52 VCC Net-_U2-+_ 10k
C69 0 Net-_U40-VREG_VOUT_ 1u
R50 Net-_U40-RUN_ VCC 10k
C72 0 VCC 100n
C71 0 VCC 100n
C73 0 VCC 100n
C74 0 VCC 100n
R12 Net-_U6--_ Vh3 10k
XU7 -Vh4 0 VREF Net-_U7--_ VCC TLV9061
R14 Net-_U7--_ Vh4 10k
R13 -Vh4 Net-_U7--_ 10k
XU6 -Vh3 0 VREF Net-_U6--_ VCC TLV9061
XU4 -Vh1 0 VREF Net-_U4--_ VCC TLV9061
XU3 -Vu3 0 VREF Net-_U3--_ VCC TLV9061
R6 Net-_U3--_ Vin_u3 10k
R7 -Vh1 Net-_U4--_ 10k
R5 -Vu3 Net-_U3--_ 10k
R8 Net-_U4--_ Vh1 10k
R2 Net-_U1--_ Vin_u2 10k
R1 -Vu2 Net-_U1--_ 10k
XU43 -Vu1 0 VREF Net-_U43--_ VCC TLV9061
R3 -Vu1 Net-_U43--_ 10k
XU1 -Vu2 0 VREF Net-_U1--_ VCC TLV9061
R4 Net-_U43--_ Vin_u1 10k
R11 -Vh3 Net-_U6--_ 10k
XU5 -Vh2 0 VREF Net-_U5--_ VCC TLV9061
R10 Net-_U5--_ Vh2 10k
R9 -Vh2 Net-_U5--_ 10k
C22 VCC 0 100n
XU77 +Vu3 VCC 0 CLK SDI CS23 VREF cbar2 AD5160 code=128 rab=10k rw=60
XU73 -Vu2 VCC 0 CLK SDI CS22_neg VREF cbar2 AD5160 code=128 rab=10k rw=60
XU72 -Vu2 VCC 0 CLK SDI CS12_neg VREF cbar1 AD5160 code=128 rab=10k rw=60
C19 VCC 0 100n
C20 VCC 0 100n
C28 VCC 0 100n
XU76 +Vu3 VCC 0 CLK SDI CS13 VREF cbar1 AD5160 code=128 rab=10k rw=60
C21 VCC 0 100n
XU80 -Vu3 VCC 0 CLK SDI CS13_neg VREF cbar1 AD5160 code=128 rab=10k rw=60
C27 VCC 0 100n
XU81 -Vu3 VCC 0 CLK SDI CS23_neg VREF cbar2 AD5160 code=128 rab=10k rw=60
C15 VCC 0 100n
XU70 +Vu2 VCC 0 CLK SDI CS32 VREF cbar3 AD5160 code=128 rab=10k rw=60
C10 VCC 0 100n
XU66 -Vu1 VCC 0 CLK SDI CS31_neg VREF cbar3 AD5160 code=128 rab=10k rw=60
C7 VCC 0 100n
C8 VCC 0 100n
XU63 +Vu1 VCC 0 CLK SDI CS41 VREF cbar4 AD5160 code=128 rab=10k rw=60
XU71 +Vu2 VCC 0 CLK SDI CS42 VREF cbar4 AD5160 code=128 rab=10k rw=60
C16 VCC 0 100n
XU62 +Vu1 VCC 0 CLK SDI CS31 VREF cbar3 AD5160 code=128 rab=10k rw=60
C9 VCC 0 100n
XU67 -Vu1 VCC 0 CLK SDI CS41_neg VREF cbar4 AD5160 code=128 rab=10k rw=60
C23 VCC 0 100n
XU78 +Vu3 VCC 0 CLK SDI CS33 VREF cbar3 AD5160 code=128 rab=10k rw=60
XU82 -Vu3 VCC 0 CLK SDI CS33_neg VREF cbar3 AD5160 code=128 rab=10k rw=60
C26 VCC 0 100n
XU79 +Vu3 VCC 0 CLK SDI CS43 VREF cbar4 AD5160 code=128 rab=10k rw=60
XU75 -Vu2 VCC 0 CLK SDI CS42_neg VREF cbar4 AD5160 code=128 rab=10k rw=60
C17 VCC 0 100n
C25 VCC 0 100n
C24 VCC 0 100n
XU83 -Vu3 VCC 0 CLK SDI CS43_neg VREF cbar4 AD5160 code=128 rab=10k rw=60
C18 VCC 0 100n
XU74 -Vu2 VCC 0 CLK SDI CS32_neg VREF cbar3 AD5160 code=128 rab=10k rw=60
XU64 -Vu1 VCC 0 CLK SDI CS11_neg VREF cbar1 AD5160 code=128 rab=10k rw=60
C12 VCC 0 100n
XU68 +Vu2 VCC 0 CLK SDI CS12 VREF cbar1 AD5160 code=128 rab=10k rw=60
C13 VCC 0 100n
XU60 +Vu1 VCC 0 CLK SDI CS11 VREF cbar1 AD5160 code=128 rab=10k rw=60
C5 VCC 0 100n
C11 VCC 0 100n
XU69 +Vu2 VCC 0 CLK SDI CS22 VREF cbar2 AD5160 code=128 rab=10k rw=60
XU65 -Vu1 VCC 0 CLK SDI CS21_neg VREF cbar2 AD5160 code=128 rab=10k rw=60
C14 VCC 0 100n
C6 VCC 0 100n
XU61 +Vu1 VCC 0 CLK SDI CS21 VREF cbar2 AD5160 code=128 rab=10k rw=60
C57 VCC 0 100n
C58 VCC 0 100n
XU128 -Vh4 VCC 0 CLK SDI CS14_neg_h VREF cbar1 AD5160 code=128 rab=10k rw=60
C45 VCC 0 100n
C49 VCC 0 100n
XU120 -Vh3 VCC 0 CLK SDI CS12_neg_h VREF cbar1 AD5160 code=128 rab=10k rw=60
XU116 +Vh3 VCC 0 CLK SDI CS13_h VREF cbar1 AD5160 code=128 rab=10k rw=60
C59 VCC 0 100n
XU129 -Vh4 VCC 0 CLK SDI CS24_neg_h VREF cbar2 AD5160 code=128 rab=10k rw=60
XU124 +Vh4 VCC 0 CLK SDI CS14_h VREF cbar1 AD5160 code=128 rab=10k rw=60
C53 VCC 0 100n
C60 VCC 0 100n
XU131 -Vh4 VCC 0 CLK SDI CS44_neg_h VREF cbar4 AD5160 code=128 rab=10k rw=60
XU130 -Vh4 VCC 0 CLK SDI CS34_neg_h VREF cbar3 AD5160 code=128 rab=10k rw=60
C37 VCC 0 100n
XU108 +Vh2 VCC 0 CLK SDI CS12_h VREF cbar1 AD5160 code=128 rab=10k rw=60
C33 VCC 0 100n
XU110 +Vh2 VCC 0 CLK SDI CS32_h VREF cbar3 AD5160 code=128 rab=10k rw=60
C38 VCC 0 100n
XU109 +Vh2 VCC 0 CLK SDI CS22_h VREF cbar2 AD5160 code=128 rab=10k rw=60
C29 VCC 0 100n
XU100 +Vh1 VCC 0 CLK SDI CS11_h VREF cbar1 AD5160 code=128 rab=10k rw=60
XU106 -Vh1 VCC 0 CLK SDI CS31_neg_h VREF cbar3 AD5160 code=128 rab=10k rw=60
XU102 +Vh1 VCC 0 CLK SDI CS31_h VREF cbar3 AD5160 code=128 rab=10k rw=60
C35 VCC 0 100n
C34 VCC 0 100n
XU104 -Vh1 VCC 0 CLK SDI CS11_neg_h VREF cbar1 AD5160 code=128 rab=10k rw=60
XU105 -Vh1 VCC 0 CLK SDI CS21_neg_h VREF cbar2 AD5160 code=128 rab=10k rw=60
C30 VCC 0 100n
XU101 +Vh1 VCC 0 CLK SDI CS21_h VREF cbar2 AD5160 code=128 rab=10k rw=60
XU122 -Vh3 VCC 0 CLK SDI CS32_neg_h VREF cbar3 AD5160 code=128 rab=10k rw=60
XU119 +Vh3 VCC 0 CLK SDI CS43_h VREF cbar4 AD5160 code=128 rab=10k rw=60
C44 VCC 0 100n
XU115 -Vh2 VCC 0 CLK SDI CS42_neg_h VREF cbar4 AD5160 code=128 rab=10k rw=60
C40 VCC 0 100n
C39 VCC 0 100n
C48 VCC 0 100n
XU126 +Vh4 VCC 0 CLK SDI CS34_h VREF cbar3 AD5160 code=128 rab=10k rw=60
C55 VCC 0 100n
C56 VCC 0 100n
XU127 +Vh4 VCC 0 CLK SDI CS44_h VREF cbar4 AD5160 code=128 rab=10k rw=60
XU123 -Vh3 VCC 0 CLK SDI CS42_neg_h VREF cbar4 AD5160 code=128 rab=10k rw=60
C52 VCC 0 100n
C43 VCC 0 100n
XU114 -Vh2 VCC 0 CLK SDI CS32_neg_h VREF cbar3 AD5160 code=128 rab=10k rw=60
C46 VCC 0 100n
XU117 +Vh3 VCC 0 CLK SDI CS23_h VREF cbar2 AD5160 code=128 rab=10k rw=60
XU113 -Vh2 VCC 0 CLK SDI CS22_neg_h VREF cbar2 AD5160 code=128 rab=10k rw=60
C47 VCC 0 100n
XU118 +Vh3 VCC 0 CLK SDI CS33_h VREF cbar3 AD5160 code=128 rab=10k rw=60
C42 VCC 0 100n
C54 VCC 0 100n
XU125 +Vh4 VCC 0 CLK SDI CS24_h VREF cbar2 AD5160 code=128 rab=10k rw=60
XU121 -Vh3 VCC 0 CLK SDI CS22_neg_h VREF cbar2 AD5160 code=128 rab=10k rw=60
C51 VCC 0 100n
C50 VCC 0 100n
XU107 -Vh1 VCC 0 CLK SDI CS41_neg_h VREF cbar4 AD5160 code=128 rab=10k rw=60
XU111 +Vh2 VCC 0 CLK SDI CS42_h VREF cbar4 AD5160 code=128 rab=10k rw=60
C41 VCC 0 100n
XU112 -Vh2 VCC 0 CLK SDI CS12_neg_h VREF cbar1 AD5160 code=128 rab=10k rw=60
C36 VCC 0 100n
C31 VCC 0 100n
C32 VCC 0 100n
XU103 +Vh1 VCC 0 CLK SDI CS41_h VREF cbar4 AD5160 code=128 rab=10k rw=60
XU9 Net-_R16-Pad2_ 0 Net-_U9-+_ Net-_U9--_ VCC TLV9061
R19 Net-_R16-Pad2_ Net-_U10--_ 10k
R18 Net-_R16-Pad2_ VREF 10k
R16 Net-_U9--_ Net-_R16-Pad2_ 10k
R17 Net-_U9--_ VREF 10k
C2 Net-_U14--_ Net-_U15-+_ 100n
R45 Net-_U14--_ Net-_U15-+_ 10Meg
XU15 Vh2 0 Net-_U15-+_ Vh2 VCC TLV9061
XU14 Net-_U15-+_ 0 VREF Net-_U14--_ VCC TLV9061
XU12 Net-_U13-+_ 0 VREF cbar1 VCC TLV9061
R22 cbar1 Net-_U13-+_ 10k
XU13 Net-_R20-Pad1_ 0 Net-_U13-+_ Net-_U13--_ VCC TLV9061
R20 Net-_R20-Pad1_ Net-_U14--_ 10k
R21 Net-_R20-Pad1_ VREF 10k
R23 Net-_U13--_ Net-_R20-Pad1_ 10k
R24 Net-_U13--_ VREF 10k
XU10 Net-_U11-+_ 0 VREF Net-_U10--_ VCC TLV9061
XU11 Vh1 0 Net-_U11-+_ Vh1 VCC TLV9061
R44 Net-_U10--_ Net-_U11-+_ 10Meg
C1 Net-_U10--_ Net-_U11-+_ 100n
R15 cbar1 Net-_U9-+_ 10k
XU8 Net-_U9-+_ 0 VREF cbar1 VCC TLV9061
C4 Net-_U22--_ Net-_U23-+_ 100n
R46 Net-_U18--_ Net-_U19-+_ 10Meg
XU23 Vh4 0 Net-_U23-+_ Vh4 VCC TLV9061
R47 Net-_U22--_ Net-_U23-+_ 10Meg
XU22 Net-_U23-+_ 0 VREF Net-_U22--_ VCC TLV9061
XU17 Net-_R25-Pad1_ 0 Net-_U17-+_ Net-_U17--_ VCC TLV9061
XU16 Net-_U17-+_ 0 VREF cbar1 VCC TLV9061
R27 cbar1 Net-_U17-+_ 10k
R28 Net-_U17--_ Net-_R25-Pad1_ 10k
R29 Net-_U17--_ VREF 10k
R26 Net-_R25-Pad1_ VREF 10k
R25 Net-_R25-Pad1_ Net-_U18--_ 10k
XU19 Vh3 0 Net-_U19-+_ Vh3 VCC TLV9061
C3 Net-_U18--_ Net-_U19-+_ 100n
XU18 Net-_U19-+_ 0 VREF Net-_U18--_ VCC TLV9061
XU21 Net-_R30-Pad1_ 0 Net-_U21-+_ Net-_U21--_ VCC TLV9061
R33 Net-_U21--_ Net-_R30-Pad1_ 10k
R32 cbar1 Net-_U21-+_ 10k
XU20 Net-_U21-+_ 0 VREF cbar1 VCC TLV9061
R30 Net-_R30-Pad1_ Net-_U22--_ 10k
R31 Net-_R30-Pad1_ VREF 10k
R34 Net-_U21--_ VREF 10k
XU31 Net-(U31-W) VCC 0 CLK SDI Wo2_neg VREF Net-(U28-A) AD5160 code=128 rab=10k rw=60
C62 VCC 0 100n
XU33 Net-(U33-W) VCC 0 CLK SDI Wo3_neg VREF Net-(U28-A) AD5160 code=128 rab=10k rw=60
XU34 Vh4_forward VCC 0 CLK SDI Wo4 VREF Net-(U28-A) AD5160 code=128 rab=10k rw=60
C66 VCC 0 100n
R35 Net-_U29-W_ Net-_U24--_ 10k
XU25 Net-_U31-W_ 0 VREF Net-_U25--_ VCC TLV9061
R37 Net-_U31-W_ Net-_U25--_ 10k
R36 Net-_U24--_ Vh1_forward 10k
R38 Net-_U25--_ Vh2_forward 10k
XU24 Net-_U29-W_ 0 VREF Net-_U24--_ VCC TLV9061
R40 Net-_U26--_ Vh3_forward 10k
R42 Net-_U27--_ Vh4_forward 10k
R41 Net-_U35-W_ Net-_U27--_ 10k
XU27 Net-_U35-W_ 0 VREF Net-_U27--_ VCC TLV9061
R39 Net-_U33-W_ Net-_U26--_ 10k
XU26 Net-_U33-W_ 0 VREF Net-_U26--_ VCC TLV9061
C67 VCC 0 100n
XU30 Vh2_forward VCC 0 CLK SDI Wo2 VREF Net-(U28-A) AD5160 code=128 rab=10k rw=60
XU29 Net-(U29-W) VCC 0 CLK SDI Wo1_neg VREF Net-(U28-A) AD5160 code=128 rab=10k rw=60
C61 VCC 0 100n
C68 VCC 0 100n
XU28 Vh1_forward VCC 0 CLK SDI Wo1 VREF Net-(U28-A) AD5160 code=128 rab=10k rw=60
C64 VCC 0 100n
C65 VCC 0 100n
XU35 Net-(U35-W) VCC 0 CLK SDI Wo4_neg VREF Net-(U28-A) AD5160 code=128 rab=10k rw=60
XU92 torque 0 VREF Net-_U28-A_ VCC TLV9061
R43 Net-_U28-A_ torque 10k
C63 VCC 0 100n
XU32 Vh3_forward VCC 0 CLK SDI Wo3 VREF Net-(U28-A) AD5160 code=128 rab=10k rw=60
VVCC_src VCC 0 DC 3.3
VVREF_src VREF 0 DC 1.65
.op
.end
