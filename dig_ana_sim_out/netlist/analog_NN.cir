.title KiCad schematic
.include "/Users/joon/Projects/Wim/analog_NN/TLV9061_generic.lib"
C78 Net-_U42-EN_ GND 10u
U42 __U42
J1 __J1
R48 Net-_J1-CC1_ GND 5.1k
R49 Net-_J1-CC2_ GND 5.1k
C80 Net-_U42-EN_ GND 1u
C81 GND VREF 10u
U40 __U40
R51 Net-_C75-Pad1_ Net-_U40-XOUT_ 1k
Y1 __Y1
C75 Net-_C75-Pad1_ GND 15p
XU2 VREF GND Net-_U2-+_ VREF VCC TLV9061
C70 GND VCC 100n
U41 __U41
C76 Net-_U40-XIN_ GND 15p
R53 Net-_U2-+_ GND 10k
C77 Net-_U42-BP_ GND 470p
C79 VCC GND 10u
C82 GND Net-_U2-+_ 100n
R52 VCC Net-_U2-+_ 10k
C69 GND Net-_U40-VREG_VOUT_ 1u
R50 Net-_U40-RUN_ VCC 10k
C72 GND VCC 100n
C71 GND VCC 100n
C73 GND VCC 100n
C74 GND VCC 100n
R12 Net-_U6--_ Vh3 10k
XU7 -Vh4 GND VREF Net-_U7--_ VCC TLV9061
R14 Net-_U7--_ Vh4 10k
R13 -Vh4 Net-_U7--_ 10k
XU6 -Vh3 GND VREF Net-_U6--_ VCC TLV9061
XU4 -Vh1 GND VREF Net-_U4--_ VCC TLV9061
XU3 -Vu3 GND VREF Net-_U3--_ VCC TLV9061
R6 Net-_U3--_ Vin_u3 10k
R7 -Vh1 Net-_U4--_ 10k
R5 -Vu3 Net-_U3--_ 10k
R8 Net-_U4--_ Vh1 10k
R2 Net-_U1--_ Vin_u2 10k
R1 -Vu2 Net-_U1--_ 10k
XU43 -Vu1 GND VREF Net-_U43--_ VCC TLV9061
R3 -Vu1 Net-_U43--_ 10k
XU1 -Vu2 GND VREF Net-_U1--_ VCC TLV9061
R4 Net-_U43--_ Vin_u1 10k
R11 -Vh3 Net-_U6--_ 10k
XU5 -Vh2 GND VREF Net-_U5--_ VCC TLV9061
R10 Net-_U5--_ Vh2 10k
R9 -Vh2 Net-_U5--_ 10k
C22 VCC GND 100n
U77 __U77
U73 __U73
U72 __U72
C19 VCC GND 100n
C20 VCC GND 100n
C28 VCC GND 100n
U76 __U76
C21 VCC GND 100n
U80 __U80
C27 VCC GND 100n
U81 __U81
C15 VCC GND 100n
U70 __U70
C10 VCC GND 100n
U66 __U66
C7 VCC GND 100n
C8 VCC GND 100n
U63 __U63
U71 __U71
C16 VCC GND 100n
U62 __U62
C9 VCC GND 100n
U67 __U67
C23 VCC GND 100n
U78 __U78
U82 __U82
C26 VCC GND 100n
U79 __U79
U75 __U75
C17 VCC GND 100n
C25 VCC GND 100n
C24 VCC GND 100n
U83 __U83
C18 VCC GND 100n
U74 __U74
U64 __U64
C12 VCC GND 100n
U68 __U68
C13 VCC GND 100n
U60 __U60
C5 VCC GND 100n
C11 VCC GND 100n
U69 __U69
U65 __U65
C14 VCC GND 100n
C6 VCC GND 100n
U61 __U61
C57 VCC GND 100n
C58 VCC GND 100n
U128 __U128
C45 VCC GND 100n
C49 VCC GND 100n
U120 __U120
U116 __U116
C59 VCC GND 100n
U129 __U129
U124 __U124
C53 VCC GND 100n
C60 VCC GND 100n
U131 __U131
U130 __U130
C37 VCC GND 100n
U108 __U108
C33 VCC GND 100n
U110 __U110
C38 VCC GND 100n
U109 __U109
C29 VCC GND 100n
U100 __U100
U106 __U106
U102 __U102
C35 VCC GND 100n
C34 VCC GND 100n
U104 __U104
U105 __U105
C30 VCC GND 100n
U101 __U101
U122 __U122
U119 __U119
C44 VCC GND 100n
U115 __U115
C40 VCC GND 100n
C39 VCC GND 100n
C48 VCC GND 100n
U126 __U126
C55 VCC GND 100n
C56 VCC GND 100n
U127 __U127
U123 __U123
C52 VCC GND 100n
C43 VCC GND 100n
U114 __U114
C46 VCC GND 100n
U117 __U117
U113 __U113
C47 VCC GND 100n
U118 __U118
C42 VCC GND 100n
C54 VCC GND 100n
U125 __U125
U121 __U121
C51 VCC GND 100n
C50 VCC GND 100n
U107 __U107
U111 __U111
C41 VCC GND 100n
U112 __U112
C36 VCC GND 100n
C31 VCC GND 100n
C32 VCC GND 100n
U103 __U103
XU9 Net-_R16-Pad2_ GND Net-_U9-+_ Net-_U9--_ VCC TLV9061
R19 Net-_R16-Pad2_ Net-_U10--_ 10k
R18 Net-_R16-Pad2_ VREF 10k
R16 Net-_U9--_ Net-_R16-Pad2_ 10k
R17 Net-_U9--_ VREF 10k
C2 Net-_U14--_ Net-_U15-+_ 100n
R45 Net-_U14--_ Net-_U15-+_ 10Meg
XU15 Vh2 GND Net-_U15-+_ Vh2 VCC TLV9061
XU14 Net-_U15-+_ GND VREF Net-_U14--_ VCC TLV9061
XU12 Net-_U13-+_ GND VREF cbar1 VCC TLV9061
R22 cbar1 Net-_U13-+_ 10k
XU13 Net-_R20-Pad1_ GND Net-_U13-+_ Net-_U13--_ VCC TLV9061
R20 Net-_R20-Pad1_ Net-_U14--_ 10k
R21 Net-_R20-Pad1_ VREF 10k
R23 Net-_U13--_ Net-_R20-Pad1_ 10k
R24 Net-_U13--_ VREF 10k
XU10 Net-_U11-+_ GND VREF Net-_U10--_ VCC TLV9061
XU11 Vh1 GND Net-_U11-+_ Vh1 VCC TLV9061
R44 Net-_U10--_ Net-_U11-+_ 10Meg
C1 Net-_U10--_ Net-_U11-+_ 100n
R15 cbar1 Net-_U9-+_ 10k
XU8 Net-_U9-+_ GND VREF cbar1 VCC TLV9061
C4 Net-_U22--_ Net-_U23-+_ 100n
R46 Net-_U18--_ Net-_U19-+_ 10Meg
XU23 Vh4 GND Net-_U23-+_ Vh4 VCC TLV9061
R47 Net-_U22--_ Net-_U23-+_ 10Meg
XU22 Net-_U23-+_ GND VREF Net-_U22--_ VCC TLV9061
XU17 Net-_R25-Pad1_ GND Net-_U17-+_ Net-_U17--_ VCC TLV9061
XU16 Net-_U17-+_ GND VREF cbar1 VCC TLV9061
R27 cbar1 Net-_U17-+_ 10k
R28 Net-_U17--_ Net-_R25-Pad1_ 10k
R29 Net-_U17--_ VREF 10k
R26 Net-_R25-Pad1_ VREF 10k
R25 Net-_R25-Pad1_ Net-_U18--_ 10k
XU19 Vh3 GND Net-_U19-+_ Vh3 VCC TLV9061
C3 Net-_U18--_ Net-_U19-+_ 100n
XU18 Net-_U19-+_ GND VREF Net-_U18--_ VCC TLV9061
XU21 Net-_R30-Pad1_ GND Net-_U21-+_ Net-_U21--_ VCC TLV9061
R33 Net-_U21--_ Net-_R30-Pad1_ 10k
R32 cbar1 Net-_U21-+_ 10k
XU20 Net-_U21-+_ GND VREF cbar1 VCC TLV9061
R30 Net-_R30-Pad1_ Net-_U22--_ 10k
R31 Net-_R30-Pad1_ VREF 10k
R34 Net-_U21--_ VREF 10k
U31 __U31
C62 VCC GND 100n
U33 __U33
U34 __U34
C66 VCC GND 100n
R35 Net-_U29-W_ Net-_U24--_ 10k
XU25 Net-_U31-W_ GND VREF Net-_U25--_ VCC TLV9061
R37 Net-_U31-W_ Net-_U25--_ 10k
R36 Net-_U24--_ Vh1_forward 10k
R38 Net-_U25--_ Vh2_forward 10k
XU24 Net-_U29-W_ GND VREF Net-_U24--_ VCC TLV9061
R40 Net-_U26--_ Vh3_forward 10k
R42 Net-_U27--_ Vh4_forward 10k
R41 Net-_U35-W_ Net-_U27--_ 10k
XU27 Net-_U35-W_ GND VREF Net-_U27--_ VCC TLV9061
R39 Net-_U33-W_ Net-_U26--_ 10k
XU26 Net-_U33-W_ GND VREF Net-_U26--_ VCC TLV9061
C67 VCC GND 100n
U30 __U30
U29 __U29
C61 VCC GND 100n
C68 VCC GND 100n
U28 __U28
C64 VCC GND 100n
C65 VCC GND 100n
U35 __U35
XU92 torque GND VREF Net-_U28-A_ VCC TLV9061
R43 Net-_U28-A_ torque 10k
C63 VCC GND 100n
U32 __U32
U37 __U37
U38 __U38
U39 __U39
U36 __U36
U93 __U93
U94 __U94
U95 __U95
U96 __U96
.end
