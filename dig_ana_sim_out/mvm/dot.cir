.title analog dot product
.include "/Users/joon/Projects/Wim/analog_NN/TLV9061_generic.lib"
* ============================================================
* AD5160.lib  —  behavioral model of the Analog Devices AD5160
* 256-position SPI digital potentiometer, for functional ngspice
* simulation of the analog_NN crossbar (pots used as synaptic weights).
*
* The resistive element A-W-B is modeled as two code-programmed
* resistors:
*     R_WB = (code/256)*R_AB + R_W        (wiper -> B)
*     R_WA = ((256-code)/256)*R_AB + R_W  (wiper -> A)
* with code in 0..255, R_AB the end-to-end resistance (part option;
* 10 k default here), and R_W ~ 60 ohm wiper resistance.
*
* Node order matches the KiCad symbol pin NUMBERS (SOT-23-8):
*   1 = W    (wiper)
*   2 = VDD
*   3 = GND
*   4 = CLK  (SPI clock)   \
*   5 = SDI  (SPI data)     >  digital control — set by shift chain / MCU;
*   6 = ~CS  (chip select) /   the resulting wiper code arrives as a param.
*   7 = B
*   8 = A
* The digital pins are not electrically modeled here (the digital/firmware
* simulator drives them and the bridge converts the SPI code -> `code`).
* Weak pulldowns keep those nets from floating in analog-only runs.
* ============================================================
.subckt AD5160 W VDD GND CLK SDI CS B A PARAMS: code=128 rab=10k rw=60
Rwb W B {(code/256)*rab + rw}
Rwa W A {((256-code)/256)*rab + rw}
* keep SPI control nets solvable when no digital driver is present
Rclk CLK 0 1G
Rsdi SDI 0 1G
Rcs  CS  0 1G
.ends AD5160

VCC vcc 0 DC 3.3
VRF vref 0 DC 1.65
VIN0 in0 0 DC 1.8
VIN1 in1 0 DC 1.5
VIN2 in2 0 DC 1.7
X0 sj vcc 0 clk0 sdi0 cs0 in0 anc0 AD5160 code=120
X1 sj vcc 0 clk1 sdi1 cs1 in1 anc1 AD5160 code=200
X2 sj vcc 0 clk2 sdi2 cs2 in2 anc2 AD5160 code=64
Rf out sj 10000.0
XU out 0 vref sj vcc TLV9061
.op
.end
